* Extracted by KLayout with GF180MCU LVS runset on : 30/09/2026 22:11

.SUBCKT diffpair
M$1 B B B vss nfet_03v3 L=0.28U W=3U AS=2.19P AD=2.19P PS=7.46U PD=7.46U
M$2 VDD2 VN VTAIL vss nfet_03v3 L=0.28U W=3U AS=2.25P AD=1.29P PS=7.5U PD=3.86U
M$3 VTAIL VN VDD2 vss nfet_03v3 L=0.28U W=3U AS=1.29P AD=1.29P PS=3.86U PD=3.86U
M$4 VDD2 VN VTAIL vss nfet_03v3 L=0.28U W=3U AS=1.29P AD=1.29P PS=3.86U PD=3.86U
M$5 VTAIL VN VDD2 vss nfet_03v3 L=0.28U W=3U AS=1.29P AD=2.25P PS=3.86U PD=7.5U
M$6 VDD1 VP VTAIL vss nfet_03v3 L=0.28U W=3U AS=2.25P AD=1.29P PS=7.5U PD=3.86U
M$7 VTAIL VP VDD1 vss nfet_03v3 L=0.28U W=3U AS=1.29P AD=1.29P PS=3.86U PD=3.86U
M$8 VDD1 VP VTAIL vss nfet_03v3 L=0.28U W=3U AS=1.29P AD=1.29P PS=3.86U PD=3.86U
M$9 VTAIL VP VDD1 vss nfet_03v3 L=0.28U W=3U AS=1.29P AD=2.25P PS=3.86U PD=7.5U
M$10 B B B vss nfet_03v3 L=0.28U W=3U AS=2.19P AD=2.19P PS=7.46U PD=7.46U
M$11 B B B vss nfet_03v3 L=0.28U W=3U AS=2.19P AD=2.19P PS=7.46U PD=7.46U
M$12 VDD1 VP VTAIL vss nfet_03v3 L=0.28U W=3U AS=2.25P AD=1.29P PS=7.5U PD=3.86U
M$13 VTAIL VP VDD1 vss nfet_03v3 L=0.28U W=3U AS=1.29P AD=1.29P PS=3.86U
+ PD=3.86U
M$14 VDD1 VP VTAIL vss nfet_03v3 L=0.28U W=3U AS=1.29P AD=1.29P PS=3.86U
+ PD=3.86U
M$15 VTAIL VP VDD1 vss nfet_03v3 L=0.28U W=3U AS=1.29P AD=2.25P PS=3.86U PD=7.5U
M$16 VDD2 VN VTAIL vss nfet_03v3 L=0.28U W=3U AS=2.25P AD=1.29P PS=7.5U PD=3.86U
M$17 VTAIL VN VDD2 vss nfet_03v3 L=0.28U W=3U AS=1.29P AD=1.29P PS=3.86U
+ PD=3.86U
M$18 VDD2 VN VTAIL vss nfet_03v3 L=0.28U W=3U AS=1.29P AD=1.29P PS=3.86U
+ PD=3.86U
M$19 VTAIL VN VDD2 vss nfet_03v3 L=0.28U W=3U AS=1.29P AD=2.25P PS=3.86U PD=7.5U
M$20 B B B vss nfet_03v3 L=0.28U W=3U AS=2.19P AD=2.19P PS=7.46U PD=7.46U
.ENDS diffpair
